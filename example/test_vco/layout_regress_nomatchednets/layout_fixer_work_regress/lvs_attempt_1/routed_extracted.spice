* NGSPICE file created from routed.ext - technology: sky130A

.subckt Unnamed_a319e946 D S G B
X0 B B B B sky130_fd_pr__nfet_01v8 ad=9.5 pd=40.95 as=38 ps=163.8 w=20 l=0.15
X1 B B B B sky130_fd_pr__nfet_01v8 ad=9.5 pd=40.95 as=0 ps=0 w=20 l=0.15
X2 D G S B sky130_fd_pr__nfet_01v8 ad=9.5 pd=40.95 as=9.5 ps=40.95 w=20 l=0.15
.ends

.subckt XN0 Unnamed_a319e946_0/S Unnamed_a319e946_0/G Unnamed_a319e946_0/D VSUBS
XUnnamed_a319e946_0 Unnamed_a319e946_0/D Unnamed_a319e946_0/S Unnamed_a319e946_0/G
+ VSUBS Unnamed_a319e946
.ends

.subckt Unnamed_9bb2e723 a_n1104_n2041# a_242_n1500# a_64_n1500# a_n242_n1696# a_n320_n1500#
X0 a_n242_n1696# a_n242_n1696# a_n320_n1500# a_n1104_n2041# sky130_fd_pr__nfet_01v8 ad=5.85 pd=30.78 as=5.85 ps=30.78 w=15 l=0.5
X1 a_242_n1500# a_n242_n1696# a_64_n1500# a_n1104_n2041# sky130_fd_pr__nfet_01v8 ad=5.85 pd=30.78 as=5.85 ps=30.78 w=15 l=0.5
X2 a_242_n1500# a_n242_n1696# a_64_n1500# a_n1104_n2041# sky130_fd_pr__nfet_01v8 ad=5.85 pd=30.78 as=5.85 ps=30.78 w=15 l=0.5
X3 a_242_n1500# a_n242_n1696# a_64_n1500# a_n1104_n2041# sky130_fd_pr__nfet_01v8 ad=5.85 pd=30.78 as=5.85 ps=30.78 w=15 l=0.5
X4 a_242_n1500# a_n242_n1696# a_64_n1500# a_n1104_n2041# sky130_fd_pr__nfet_01v8 ad=5.85 pd=30.78 as=5.85 ps=30.78 w=15 l=0.5
X5 a_n1104_n2041# a_n1104_n2041# a_n1104_n2041# a_n1104_n2041# sky130_fd_pr__nfet_01v8 ad=5.85 pd=30.78 as=11.7 ps=61.56 w=15 l=0.5
.ends

.subckt current_mirror_XN5_XN4 Unnamed_9bb2e723_0/a_n320_n1500# Unnamed_9bb2e723_0/a_242_n1500#
+ Unnamed_9bb2e723_0/a_n242_n1696# Unnamed_9bb2e723_0/a_64_n1500# VSUBS
XUnnamed_9bb2e723_0 VSUBS Unnamed_9bb2e723_0/a_242_n1500# Unnamed_9bb2e723_0/a_64_n1500#
+ Unnamed_9bb2e723_0/a_n242_n1696# Unnamed_9bb2e723_0/a_n320_n1500# Unnamed_9bb2e723
.ends

.subckt Unnamed_a58330e8 c1_n750_n750# m3_n1218_n200#
X0 c1_n750_n750# m3_n1218_n200# sky130_fd_pr__cap_mim_m3_1 l=7.5 w=7.5
.ends

.subckt XC0 Unnamed_a58330e8_0/m3_n1218_n200# Unnamed_a58330e8_0/c1_n750_n750#
XUnnamed_a58330e8_0 Unnamed_a58330e8_0/c1_n750_n750# Unnamed_a58330e8_0/m3_n1218_n200#
+ Unnamed_a58330e8
.ends

.subckt Unnamed_c05d91ed D S G B
X0 D G S B sky130_fd_pr__nfet_01v8 ad=23.4 pd=120.78 as=23.4 ps=120.78 w=60 l=0.5
X1 B B B B sky130_fd_pr__nfet_01v8 ad=23.4 pd=120.78 as=93.6 ps=483.12 w=60 l=0.5
X2 B B B B sky130_fd_pr__nfet_01v8 ad=23.4 pd=120.78 as=0 ps=0 w=60 l=0.5
.ends

.subckt XN3 Unnamed_c05d91ed_0/G Unnamed_c05d91ed_0/D Unnamed_c05d91ed_0/S VSUBS
XUnnamed_c05d91ed_0 Unnamed_c05d91ed_0/D Unnamed_c05d91ed_0/S Unnamed_c05d91ed_0/G
+ VSUBS Unnamed_c05d91ed
.ends

.subckt Unnamed_70e20656 D S G B
X0 B B B B sky130_fd_pr__nfet_01v8 ad=9.5 pd=40.95 as=38 ps=163.8 w=20 l=0.15
X1 B B B B sky130_fd_pr__nfet_01v8 ad=9.5 pd=40.95 as=0 ps=0 w=20 l=0.15
X2 D G S B sky130_fd_pr__nfet_01v8 ad=9.5 pd=40.95 as=9.5 ps=40.95 w=20 l=0.15
.ends

.subckt XN1 Unnamed_70e20656_0/S Unnamed_70e20656_0/G Unnamed_70e20656_0/D VSUBS
XUnnamed_70e20656_0 Unnamed_70e20656_0/D Unnamed_70e20656_0/S Unnamed_70e20656_0/G
+ VSUBS Unnamed_70e20656
.ends

.subckt Unnamed_b1a60056 c1_n750_n750# m3_n1218_n200#
X0 c1_n750_n750# m3_n1218_n200# sky130_fd_pr__cap_mim_m3_1 l=7.5 w=7.5
.ends

.subckt XC1 Unnamed_b1a60056_0/m3_n1218_n200# Unnamed_b1a60056_0/c1_n750_n750#
XUnnamed_b1a60056_0 Unnamed_b1a60056_0/c1_n750_n750# Unnamed_b1a60056_0/m3_n1218_n200#
+ Unnamed_b1a60056
.ends

.subckt Unnamed_fe6ee434 D S G B
X0 D G S B sky130_fd_pr__nfet_01v8 ad=23.4 pd=120.78 as=23.4 ps=120.78 w=60 l=0.5
X1 B B B B sky130_fd_pr__nfet_01v8 ad=23.4 pd=120.78 as=93.6 ps=483.12 w=60 l=0.5
X2 B B B B sky130_fd_pr__nfet_01v8 ad=23.4 pd=120.78 as=0 ps=0 w=60 l=0.5
.ends

.subckt XN2 Unnamed_fe6ee434_0/S Unnamed_fe6ee434_0/G Unnamed_fe6ee434_0/D VSUBS
XUnnamed_fe6ee434_0 Unnamed_fe6ee434_0/D Unnamed_fe6ee434_0/S Unnamed_fe6ee434_0/G
+ VSUBS Unnamed_fe6ee434
.ends

.subckt routed VDD Vcont voutn voutp VSS Iref
XXN0_0 XN1_0/Unnamed_70e20656_0/S voutp voutn VSS XN0
Xcurrent_mirror_XN5_XN4_0 VSS XN1_0/Unnamed_70e20656_0/S Iref VSS VSS current_mirror_XN5_XN4
XXC0_0 voutp VDD XC0
XXN3_0 voutn Vcont Vcont VSS XN3
XXN1_0 XN1_0/Unnamed_70e20656_0/S voutn voutp VSS XN1
XXC1_0 voutn VDD XC1
XXN2_0 Vcont voutp Vcont VSS XN2
.ends
