* NGSPICE file created from routed.ext - technology: sky130A

.subckt Unnamed_b8d8d2c8 D S G B
X0 B B B B sky130_fd_pr__nfet_01v8 ad=9.5 pd=40.95 as=38 ps=163.8 w=20 l=0.15
X1 B B B B sky130_fd_pr__nfet_01v8 ad=9.5 pd=40.95 as=0 ps=0 w=20 l=0.15
X2 D G S B sky130_fd_pr__nfet_01v8 ad=9.5 pd=40.95 as=9.5 ps=40.95 w=20 l=0.15
.ends

.subckt XN0 Unnamed_b8d8d2c8_0/D Unnamed_b8d8d2c8_0/S VSUBS Unnamed_b8d8d2c8_0/G
XUnnamed_b8d8d2c8_0 Unnamed_b8d8d2c8_0/D Unnamed_b8d8d2c8_0/S Unnamed_b8d8d2c8_0/G
+ VSUBS Unnamed_b8d8d2c8
.ends

.subckt Unnamed_c2c574c1 a_n1104_n2041# a_242_n1500# a_64_n1500# a_n242_n1696# a_n320_n1500#
X0 a_n242_n1696# a_n242_n1696# a_n320_n1500# a_n1104_n2041# sky130_fd_pr__nfet_01v8 ad=5.85 pd=30.78 as=5.85 ps=30.78 w=15 l=0.5
X1 a_242_n1500# a_n242_n1696# a_64_n1500# a_n1104_n2041# sky130_fd_pr__nfet_01v8 ad=5.85 pd=30.78 as=5.85 ps=30.78 w=15 l=0.5
X2 a_242_n1500# a_n242_n1696# a_64_n1500# a_n1104_n2041# sky130_fd_pr__nfet_01v8 ad=5.85 pd=30.78 as=5.85 ps=30.78 w=15 l=0.5
X3 a_242_n1500# a_n242_n1696# a_64_n1500# a_n1104_n2041# sky130_fd_pr__nfet_01v8 ad=5.85 pd=30.78 as=5.85 ps=30.78 w=15 l=0.5
X4 a_242_n1500# a_n242_n1696# a_64_n1500# a_n1104_n2041# sky130_fd_pr__nfet_01v8 ad=5.85 pd=30.78 as=5.85 ps=30.78 w=15 l=0.5
X5 a_n1104_n2041# a_n1104_n2041# a_n1104_n2041# a_n1104_n2041# sky130_fd_pr__nfet_01v8 ad=5.85 pd=30.78 as=11.7 ps=61.56 w=15 l=0.5
.ends

.subckt current_mirror_XN5_XN4 Unnamed_c2c574c1_0/a_n242_n1696# Unnamed_c2c574c1_0/a_242_n1500#
+ Unnamed_c2c574c1_0/a_64_n1500# VSUBS Unnamed_c2c574c1_0/a_n320_n1500#
XUnnamed_c2c574c1_0 VSUBS Unnamed_c2c574c1_0/a_242_n1500# Unnamed_c2c574c1_0/a_64_n1500#
+ Unnamed_c2c574c1_0/a_n242_n1696# Unnamed_c2c574c1_0/a_n320_n1500# Unnamed_c2c574c1
.ends

.subckt Unnamed_5d39a6f6 c1_n750_n750# m3_n1218_n200#
X0 c1_n750_n750# m3_n1218_n200# sky130_fd_pr__cap_mim_m3_1 l=7.5 w=7.5
.ends

.subckt XC0 Unnamed_5d39a6f6_0/m3_n1218_n200# Unnamed_5d39a6f6_0/c1_n750_n750#
XUnnamed_5d39a6f6_0 Unnamed_5d39a6f6_0/c1_n750_n750# Unnamed_5d39a6f6_0/m3_n1218_n200#
+ Unnamed_5d39a6f6
.ends

.subckt Unnamed_b74db7d7 D S G B
X0 D G S B sky130_fd_pr__nfet_01v8 ad=23.4 pd=120.78 as=23.4 ps=120.78 w=60 l=0.5
X1 B B B B sky130_fd_pr__nfet_01v8 ad=23.4 pd=120.78 as=93.6 ps=483.12 w=60 l=0.5
X2 B B B B sky130_fd_pr__nfet_01v8 ad=23.4 pd=120.78 as=0 ps=0 w=60 l=0.5
.ends

.subckt XN3 Unnamed_b74db7d7_0/G Unnamed_b74db7d7_0/D Unnamed_b74db7d7_0/S VSUBS
XUnnamed_b74db7d7_0 Unnamed_b74db7d7_0/D Unnamed_b74db7d7_0/S Unnamed_b74db7d7_0/G
+ VSUBS Unnamed_b74db7d7
.ends

.subckt Unnamed_e30dc562 D S G B
X0 B B B B sky130_fd_pr__nfet_01v8 ad=9.5 pd=40.95 as=38 ps=163.8 w=20 l=0.15
X1 B B B B sky130_fd_pr__nfet_01v8 ad=9.5 pd=40.95 as=0 ps=0 w=20 l=0.15
X2 D G S B sky130_fd_pr__nfet_01v8 ad=9.5 pd=40.95 as=9.5 ps=40.95 w=20 l=0.15
.ends

.subckt XN1 Unnamed_e30dc562_0/G Unnamed_e30dc562_0/D Unnamed_e30dc562_0/S VSUBS
XUnnamed_e30dc562_0 Unnamed_e30dc562_0/D Unnamed_e30dc562_0/S Unnamed_e30dc562_0/G
+ VSUBS Unnamed_e30dc562
.ends

.subckt Unnamed_7533bd66 c1_n750_n750# m3_n1218_n200#
X0 c1_n750_n750# m3_n1218_n200# sky130_fd_pr__cap_mim_m3_1 l=7.5 w=7.5
.ends

.subckt XC1 Unnamed_7533bd66_0/m3_n1218_n200# Unnamed_7533bd66_0/c1_n750_n750#
XUnnamed_7533bd66_0 Unnamed_7533bd66_0/c1_n750_n750# Unnamed_7533bd66_0/m3_n1218_n200#
+ Unnamed_7533bd66
.ends

.subckt Unnamed_4ab843b8 D S G B
X0 D G S B sky130_fd_pr__nfet_01v8 ad=23.4 pd=120.78 as=23.4 ps=120.78 w=60 l=0.5
X1 B B B B sky130_fd_pr__nfet_01v8 ad=23.4 pd=120.78 as=93.6 ps=483.12 w=60 l=0.5
X2 B B B B sky130_fd_pr__nfet_01v8 ad=23.4 pd=120.78 as=0 ps=0 w=60 l=0.5
.ends

.subckt XN2 Unnamed_4ab843b8_0/S Unnamed_4ab843b8_0/G Unnamed_4ab843b8_0/D VSUBS
XUnnamed_4ab843b8_0 Unnamed_4ab843b8_0/D Unnamed_4ab843b8_0/S Unnamed_4ab843b8_0/G
+ VSUBS Unnamed_4ab843b8
.ends

.subckt routed VDD voutn voutp Iref Vcont VSS
XXN0_0 voutn XN1_0/Unnamed_e30dc562_0/S VSS voutp XN0
Xcurrent_mirror_XN5_XN4_0 Iref XN1_0/Unnamed_e30dc562_0/S VSS VSS VSS current_mirror_XN5_XN4
XXC0_0 voutp VDD XC0
XXN3_0 voutn Vcont Vcont VSS XN3
XXN1_0 voutn voutp XN1_0/Unnamed_e30dc562_0/S VSS XN1
XXC1_0 voutn VDD XC1
XXN2_0 Vcont voutp Vcont VSS XN2
.ends
